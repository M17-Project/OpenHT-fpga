//-----------------------------------------------------------------------------
// OpenHT SystemRDL description
//
// OpenHT TX CTCSS
//
// December 2023 : Sebastien Van Cauwenberghe, ON4SEB
//-----------------------------------------------------------------------------


enum in_mode_enum {
    CONST = 1'd0 { desc = "Constant input from Tuning word"; };
    STREAM = 1'd1 { desc = "Frequency input from stream"; };
};

enum add_pass_enum {
    ADD = 1'd0 { desc = "Add with input stream"; };
    REPLACE = 1'd1 { desc = "Replace input stream with "; };
};

regfile openht_tx_ctcss {
    name = "OpenHT TX CTCSS regs";
    desc = "APB registers for CTCSS of OpenHT";
    
    default regwidth = 16;
    default sw = r;
    default hw = r;

    reg {
        name = "Control Register";

        field {
            desc = "Add or replace stream";
            encode = add_pass_enum;
            sw = rw; hw = r;
        } ADD_REPLACE[2:2];

        field {
            desc = "Input Mode";
            encode = in_mode_enum;
            sw = rw; hw = r;
        } IN_MODE[1:1];

        field {
            desc = "Enabled";
            sw = rw; hw = r;
        } ENABLE[0:0];

    } CTRL @0x0;

    reg {
        name = "Amplitude Register";

        field {
            desc = "CTCSS generator amplitude";
            sw = rw; hw = r;
        } AMPLITUDE[15:0];
    } AMPLITUDE @0x2;

    reg {
        name = "Tuning word Register";

        field {
            desc = "Tuning word";
            sw = rw; hw = r;
        } TW[15:0];
    } TUNING_W @0x4;

};