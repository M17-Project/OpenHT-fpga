//-----------------------------------------------------------------------------
// OpenHT SystemRDL description
//
// OpenHT TX IQ Balance
//
// December 2023 : Sebastien Van Cauwenberghe, ON4SEB
//-----------------------------------------------------------------------------

regfile openht_iq_bal {
    name = "OpenHT TX IQ Balance";
    desc = "IQ Balance";
    
    default regwidth = 16;
    default sw = r;
    default hw = r;

    reg {
        name = "I gain";

        field {
            desc = "I Gain";
            sw = rw; hw = r;
        } GAIN[15:0];
    } I_GAIN @0x0;

    reg {
        name = "Q gain";

        field {
            desc = "Q gain";
            sw = rw; hw = r;
        } GAIN[15:0];
    } Q_GAIN @0x2;

};